# Ansys Electronics Desktop project, version 2024.1
materials:
  vacuum: permittivity=1
  Isola I-Speed (R): permittivity=3.64 dielectric_loss_tangent=0.006
  pec: conductivity=1e+30

design Stacked_Antenna_3p0_3p5_Pin_Single (HFSS, HFSS Modal Network, model units mm)
variables:
  substrate = 80mm
  h_L1L2 = 3.25mm
  h_L2L3 = 3.25mm
  patch_top = 20.4mm
  patch_top_cutout = 3mm
  patch_bottom = 21.5mm
  patch_bottom_cutout = 3mm
  d_via = 0.8mm
  h_coax = 3mm
  d_coax = 3.92mm
  via_offset = 3.25mm
  h_airbox = 20mm
geometry:
  Substrate_L1L2 [Isola I-Speed (R)] = box(corner=(-substrate/2, -substrate/2, 0mm), size=(substrate, substrate, -h_L1L2))
  Substrate_L2L3 [Isola I-Speed (R)] = box(corner=(-substrate/2, -substrate/2, -h_L1L2), size=(substrate, substrate, -h_L2L3))
  Patch_Top = rectangle(corner=(-patch_top/2, -patch_top/2, 0mm), x_size=patch_top, y_size=patch_top)
  Top_Patch_Cutout = polyline(z=0mm, xy: (-patch_top/2, -patch_top/2) (-patch_top/2, -patch_top/2 + patch_top_cutout) (-patch_top/2 + patch_top_cutout, -patch_top/2) (-patch_top/2, -patch_top/2), closed, covered)
  Top_Patch_Cutout.duplicate_around_axis(axis=Z, angle=90deg, total=4, attached)
  Patch_Top.subtract(Top_Patch_Cutout)
  Circle1 = circle(normal=Z, centre=(-patch_top/2, -patch_top/2, 0mm), radius=patch_top_cutout)
  Circle1.move(patch_top_cutout, patch_top_cutout, 0mm)
  Circle1.duplicate_around_axis(axis=Z, angle=90deg, total=4, attached)
  Patch_Top.unite(Circle1)
  Patch_Bottom = rectangle(corner=(-patch_bottom/2, -patch_bottom/2, -h_L1L2), x_size=patch_bottom, y_size=patch_bottom)
  Polyline1 = polyline(z=-h_L1L2, xy: (-patch_bottom/2, -patch_bottom/2) (-patch_bottom/2, -patch_bottom/2 + patch_bottom_cutout) (-patch_bottom/2 + patch_bottom_cutout, -patch_bottom/2) (-patch_bottom/2, -patch_bottom/2), closed, covered)
  Polyline1.duplicate_around_axis(axis=Z, angle=90deg, total=4, attached)
  Patch_Bottom.subtract(Polyline1)
  Circle2 = circle(normal=Z, centre=(-patch_bottom/2, -patch_bottom/2, -h_L1L2), radius=patch_bottom_cutout)
  Circle2.move(patch_bottom_cutout, patch_bottom_cutout, 0mm)
  Circle2.duplicate_around_axis(axis=Z, angle=90deg, total=4, attached)
  Patch_Bottom.unite(Circle2)
  Via [pec] = cylinder(axis=Z, base_centre=(patch_bottom/2 - via_offset, 0mm, -h_L1L2), radius=d_via/2, height=-h_L2L3-h_coax)
  AirBox [vacuum] = box(corner=(-substrate/2, -substrate/2, -h_airbox/2), size=(substrate, substrate, h_airbox))
  Via_1 = Via.copy()
  Substrate_L2L3.subtract(Via_1)
  coax_dielectric [Isola I-Speed (R)] = cylinder(axis=Z, base_centre=(patch_bottom/2 - via_offset, 0mm, -h_L1L2-h_L2L3), radius=d_coax/2, height=-h_coax)
  Via_2 = Via.copy()
  coax_dielectric.subtract(Via_2)
  Wave_Port = circle(normal=Z, centre=(patch_bottom/2 - via_offset, 0mm, -h_L1L2-h_L2L3-h_coax), radius=d_coax/2)
  pecCap1 [pec] = sweep_along_normal(Wave_Port.face(at (7.5, 0, -9.5)), length=-0.42mm)
  coax_ground_shield = object_from(coax_dielectric.face(side))
  Ground_L3 = rectangle(corner=(-substrate/2, -substrate/2, -h_L1L2-h_L2L3), x_size=substrate, y_size=substrate)
  L3_Ground_Cutout = circle(normal=Z, centre=(patch_bottom/2 - via_offset, 0mm, -h_L1L2-h_L2L3), radius=d_coax/2)
  Ground_L3.subtract(L3_Ground_Cutout)
boundaries and excitations:
  PerfE_Patch_Top: Perfect E Objects=Patch_Top
  PerfE_Patch_Bottom: Perfect E Objects=Patch_Bottom
  Radiation: Radiation Objects=AirBox
  PerfE_Coax_Ground_Shield: Perfect E Objects=coax_ground_shield
  PerfE_Ground_L3: Perfect E Objects=Ground_L3
  1: Wave Port Objects=Wave_Port WavePortType=Modal NumModes=1 Modes{Mode1{CharImp=Zpi}}
setups:
  Setup1: HfssDriven Frequency=4GHz MaxDeltaS=0.01 MaximumPasses=20 MinimumPasses=1 MinimumConvergedPasses=1 PercentRefinement=30 BasisOrder=1 PortAccuracy=2 DrivenSolverType="Direct Solver"
    sweep Sweep: 2GHz to 5GHz, 401 points; Type=Interpolating SaveFields InterpTolerance=0.5 InterpMaxSolns=250 InterpUsePortImped=false PassivityErrorTolerance=0.0001
source amplitudes:
  1:1: 1W 0deg
optimetrics:
  ParametricSetup patch_top: Parametric disabled Sim._Setups=[Setup1]
    sweep patch_top: LIN 19mm 22mm 0.5mm
  ParametricSetup patch_bottom: Parametric disabled Sim._Setups=[Setup1]
    sweep patch_bottom: LIN 20mm 24mm 0.5mm
  ParametricSetup via_offset: Parametric disabled Sim._Setups=[Setup1]
    sweep via_offset: LIN 2mm 4mm 0.25mm
  ParametricSetup top_patch_cutout: Parametric disabled Sim._Setups=[Setup1]
    sweep patch_top_cutout: LIN 1mm 5mm 1mm
  ParametricSetup bottom_patch_cutout: Parametric disabled Sim._Setups=[Setup1]
    sweep patch_bottom_cutout: LIN 1mm 5mm 1mm
radiation setups:
  Infinite Sphere1: Infinite Sphere Theta=0deg..180deg step 2deg Phi=-180deg..180deg step 2deg
reports:
  Nominal: dB(S(1,1)) vs Freq on Setup1 : Sweep; markers m1 at 2.99GHz, m2 at 3.4925GHz
  patch_top: dB(S(1,1)) vs Freq on Setup1 : Sweep [patch_top=all]
  patch_bottom: dB(S(1,1)) vs Freq on Setup1 : Sweep [patch_bottom=all]
  via_offset: dB(S(1,1)) vs Freq on Setup1 : Sweep [via_offset=all]
  top_patch_cutout: dB(S(1,1)) vs Freq on Setup1 : Sweep [patch_top_cutout=all]
  bottom_patch_cutout: dB(S(1,1)) vs Freq on Setup1 : Sweep [patch_bottom_cutout=all]
  Gain Plot 1: GainTotal vs Phi, Theta on Setup1 : Sweep, Infinite Sphere1 [Freq=3.3125GHz]
  Realized Gain Plot 1: dB(RealizedGainTotal) vs Phi, Theta on Setup1 : Sweep, Infinite Sphere1 [Freq=3.3125GHz]
