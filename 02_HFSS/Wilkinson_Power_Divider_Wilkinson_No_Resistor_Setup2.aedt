# Ansys Electronics Desktop project, version 2024.1
materials:
  air: permittivity=1.0006 permeability=1.0000004
  vacuum: permittivity=1
  pec: conductivity=1e+30
  aluminum: permeability=1.000021 conductivity=38000000
  copper: permeability=0.999991 conductivity=58000000
  TMM_3: permittivity=3.27 permeability=1 dielectric_loss_tangent=0.0016

design Wilkinson_No_Resistor (HFSS, HFSS Hybrid Terminal Network, model units mm)
options: Allow_Material_Override Save_Adaptive_support_files
geometry:
  Dielectric [TMM_3] = imported_body()
  Ground [aluminum] = imported_body()
  Port_Port1, Port_Port2, Port_Port3 [pec] = imported_body()
  Trace [copper] = imported_body()
  airbox [air] = imported_body()
boundaries and excitations:
  airbox_RAD: Radiation Objects=airbox
  Ground_FC: Finite Conductivity Objects=Ground UseMaterial Material=aluminum Thickness=1.75e-05 Roughness=0 IsTwoSided
  Port1_T1: Terminal port=Port1 Edges=Port_Port1.edge(at (200, 157.715, 0.8128)) TerminalResistance="50ohm + 0i ohm"
  Port1: Lumped Port Faces=Port_Port1.face(at (200, 157.715, 0.4064)) LumpedPortType=Terminal RenormalizeAllTerminals=false Impedance=50ohm
  Port2_T1: Terminal port=Port2 Edges=Port_Port2.edge(at (231.596, 222.783, 0.8128)) TerminalResistance="50ohm + 0i ohm"
  Port2: Lumped Port Faces=Port_Port2.face(at (231.596, 222.783, 0.4064)) LumpedPortType=Terminal RenormalizeAllTerminals=false Impedance=50ohm
  Port3_T1: Terminal port=Port3 Edges=Port_Port3.edge(at (168.404, 222.783, 0.8128)) TerminalResistance="50ohm + 0i ohm"
  Port3: Lumped Port Faces=Port_Port3.face(at (168.404, 222.783, 0.4064)) LumpedPortType=Terminal RenormalizeAllTerminals=false Impedance=50ohm
  Trace_FC: Finite Conductivity Objects=Trace UseMaterial Material=copper Thickness=1.75e-05 Roughness=0 IsTwoSided
mesh:
  initial mesh: MeshMethod=AnsoftClassic
setups:
  Setup2: HfssDriven Frequency=4.5GHz MaxDeltaS=0.02 MaximumPasses=20 MinimumPasses=1 MinimumConvergedPasses=1 PercentRefinement=30 BasisOrder=-1 Target=0.666667 PortAccuracy=2 DrivenSolverType="Direct Solver" SaveAnyFields=false
    sweep Sweep1: 3.5GHz to 4.5GHz step 0.01GHz; Type=Interpolating InterpTolerance=0.5 InterpMaxSolns=250 PassivityErrorTolerance=0.0001
source amplitudes:
  Port1:1, Port2:1, Port3:1: 0.001V 0deg
reports:
  Terminal S Parameter Plot 1: dB(St(Port1_T1,Port1_T1)), dB(St(Port1_T1,Port2_T1)), dB(St(Port1_T1,Port3_T1)), dB(St(Port2_T1,Port3_T1)) vs Freq on Setup2 : Sweep1

design Wilkinson_with_Resistor (HFSS, HFSS Hybrid Terminal Network, model units mm)
options: Allow_Material_Override Save_Adaptive_support_files
geometry:
  Dielectric [TMM_3] = imported_body()
  Ground [aluminum] = imported_body()
  Port_Port1, Port_Port2, Port_Port3 [pec] = imported_body()
  Trace [copper] = imported_body()
  airbox [air] = imported_body()
  Rectangle1 = rectangle(corner=(196.3418058mm, 214.3096076mm, 0.8128mm), x_size=7.3163884mm, y_size=-1.465mm)
boundaries and excitations:
  airbox_RAD: Radiation Objects=airbox
  Ground_FC: Finite Conductivity Objects=Ground UseMaterial Material=aluminum Thickness=1.75e-05 Roughness=0 IsTwoSided
  LumpRLC1: Lumped RLC Objects=Rectangle1 CurrentLine{(196.3418058, 213.5771076, 0.8128) -> (203.6581942, 213.5771076, 0.8128)} RLC_Type=Parallel Resistance=100ohm
  Port1_T1: Terminal port=Port1 Edges=Port_Port1.edge(at (200, 157.715, 0.8128)) TerminalResistance="50ohm + 0i ohm"
  Port1: Lumped Port Faces=Port_Port1.face(at (200, 157.715, 0.4064)) LumpedPortType=Terminal RenormalizeAllTerminals=false Impedance=50ohm
  Port2_T1: Terminal port=Port2 Edges=Port_Port2.edge(at (231.596, 222.783, 0.8128)) TerminalResistance="50ohm + 0i ohm"
  Port2: Lumped Port Faces=Port_Port2.face(at (231.596, 222.783, 0.4064)) LumpedPortType=Terminal RenormalizeAllTerminals=false Impedance=50ohm
  Port3_T1: Terminal port=Port3 Edges=Port_Port3.edge(at (168.404, 222.783, 0.8128)) TerminalResistance="50ohm + 0i ohm"
  Port3: Lumped Port Faces=Port_Port3.face(at (168.404, 222.783, 0.4064)) LumpedPortType=Terminal RenormalizeAllTerminals=false Impedance=50ohm
  Trace_FC: Finite Conductivity Objects=Trace UseMaterial Material=copper Thickness=1.75e-05 Roughness=0 IsTwoSided
mesh:
  initial mesh: MeshMethod=AnsoftClassic
setups:
  Setup2: HfssDriven Frequency=4.5GHz MaxDeltaS=0.02 MaximumPasses=20 MinimumPasses=1 MinimumConvergedPasses=1 PercentRefinement=30 BasisOrder=-1 Target=0.666667 PortAccuracy=2 DrivenSolverType="Direct Solver" SaveAnyFields=false
    sweep Sweep1: 3.5GHz to 4.5GHz step 0.01GHz; Type=Interpolating InterpTolerance=0.5 InterpMaxSolns=250 PassivityErrorTolerance=0.0001
source amplitudes:
  Port1:1, Port2:1, Port3:1: 0.001V 0deg
reports:
  Terminal S Parameter Plot 1: dB(St(Port1_T1,Port1_T1)), dB(St(Port1_T1,Port2_T1)), dB(St(Port1_T1,Port3_T1)), dB(St(Port2_T1,Port3_T1)) vs Freq on Setup2 : Sweep1
