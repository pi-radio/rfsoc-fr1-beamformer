# Ansys Electronics Desktop project, version 2022.2
project variables:
  $antiPad = 770um  # Signal via antipad diameter.; optimise 650um..800um
materials:
  copper: permeability=0.999991 conductivity=58000000
  FR4_epoxy: permittivity=4.4 dielectric_loss_tangent=0.02
  pec: conductivity=1e+30

design diffViaNominal (HFSS 3D Layout)
notes: (23-July-2011)

This project uses HFSS "Solver on Demand" to 
run full-wave electromagnetic analysis and calculate
differential s-parameters from the via transition in the
frequency range 0-10 GHz.

The antipad diameter can be changed by modifying
the project variable $antiPad.
options: Notes='(23-July-2011) / This project uses HFSS "Solver on Demand" to / run full-wave electromagnetic analysis and calculate / differential s-parameters from the via transition in the / frequency range 0-10 GHz. / The antipad diameter can be changed by modifying / the project variable $antiPad.'
variables:
  w1 = 199.5um  # Width of top traces; optimise 198um..208um
  s1 = 150um  # Spacing between top traces
  w2 = 210um  # Width of stripline signal traces.; optimise 210um..230um
  s2 = 120um  # Spacing between stripline traces.
  viaSpacing = 1.26mm  # Spacing between signal vias.; optimise 0.9mm..1.4mm
  gndViaDist = 0.89mm  # Distance from signal via to ground via.; optimise 0.75mm..1.2mm
  bufferLen = 3mm  # Padding distance of ground metal from ground vias.
  len = 1.5mm  # Length extension of signal traces after bend.
nets:
  Port1: port Port1:T1
  Port2: port Port1:T2
  Port3: port Port3:T1
  Port4: port Port3:T2
ports:
  Port1:T1, Port1:T2: Properties{Reference=GND_1_L2:GND:rect_6 Impedance=50ohm Magnitude=1V Phase=0deg Renormalize_Impedence="50ohm + 0i ohm" Renormalize Deembed_Distance=0mm Deembed Type="Coupled Strips Gap Source" HFSS_Type=Wave Orientation=Vertical Layer_Alignment=Upper Horizontal_Extent_Factor=2 Vertical_Extent_Factor=3 PEC_Launch_Width=0.03mm} Type=EdgePortCoupledStrip
  Port3:T1, Port3:T2: Properties{Reference=GND_4_L9:GND:rect_19 Impedance=50ohm Magnitude=1V Phase=0deg Renormalize_Impedence="50ohm + 0i ohm" Renormalize Deembed_Distance=0mm Deembed Type="Coupled Strips Gap Source" HFSS_Type=Wave Orientation=Vertical Layer_Alignment=Lower Horizontal_Extent_Factor=2 Vertical_Extent_Factor=3 PEC_Launch_Width=0.03mm} Type=EdgePortCoupledStrip
setups:
  HFSS Setup 1: SolveSetupType=HFSS PercentRefinementPerPass=30 MinNumberOfPasses=1 MinNumberOfConvergedPasses=1 Frequency=10GHz MeshSizeFactor=1.5 ViaNumSides=6 ViaMaterial=copper Style25DVia=Mesh
    sweep Sweep 1: LIN 0GHz 10GHz 0.05GHz; SAbsError=0.005 ZoPercentError=1 PassivityTolerance=0.0001 MaxSolutions=250 InterpUseSMatrix InterpUsePortImpedance InterpUseFullBasis MinSolvedFreq=0.01GHz AutoSMatOnlySolve MinFreqSMatrixOnlySolve=1MHz MagMinThreshold=0.01 FreqSweepType=kInterpolating
reports:
  XY Plot 1: dB(S(Diff1,Diff1)), dB(S(Diff2,Diff1)) vs Freq on HFSS Setup 1 : Sweep 1
